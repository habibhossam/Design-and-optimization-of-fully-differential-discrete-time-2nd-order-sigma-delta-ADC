ADE simulation setup
Run mode: Single Run, Sweeps and Corners
Tests:
  Sigma_Delta_ADC:second_order:1: Sigma_Delta_ADC/second_order/schematic, simulator spectre
    Outputs: ENOB; spectrumMeasurement(getData("/VOUTP" ?result "tran") t VAR("TDROP") VAR("TSTOP") VAR("NFFT") VAR("FIN") (1.1 * VAR("FMAX")) 0 "Rectangular" 0 0 7 "enob"); SNR
Global variables:
  Ao = 10e5
  C11 = 2p
  C12 = 2p
  CS = 1p
  CS1 = 1p
  FIN = (NCYC/NFFT)/Ts
  Rsig = 1k
  Td = 0.05u
  Ton = 0.4*Ts
  Trf = 0.001*Ts
  Ts = 1u
  VCM = 0.5*(VREFN+VREFP)
  VDD = 1.8
  VIN_DC = 0.125*(VREFP-VREFN)
  VIN_MAX = VDD-0.2
  VIN_MIN = 0.2
  VOUT_MAX = VDD-0.2
  VOUT_MIN = 0.2
  VPK = A*(VREFP-VREFN)
  VREFN = 0.25*VDD
  VREFP = 0.75*VDD
  A = 0.5
  CP = 50f
  NFFT = (2**5)*OSR
  NCYC = 16
  OSR = 500
  FNYQ = 0.5/Ts
  FMAX = FNYQ/OSR
  TDROP = 0.5/FIN
  TSTOP = NCYC/FIN+TDROP
Specs:
  Sigma_Delta_ADC:second_order:1 / SNR: > 100
